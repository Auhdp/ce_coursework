*** SPICE deck for cell PMOS_lay{lay} from library PMOS
*** Created on Thu May 29, 2025 22:24:57
*** Last revised on Thu May 29, 2025 23:13:03
*** Written on Thu May 29, 2025 23:13:39 by Electric VLSI Design System, version 9.07
*** Layout tech: mocmos, foundry MOSIS
*** UC SPICE *** , MIN_RESIST 4.0, MIN_CAPAC 0.1FF
* CMOS/BULK-NWELL (PRELIMINARY PARAMETERS)
.OPTIONS NOMOD DEFL=3u DEFW=3u DEFAD=70p DEFAS=70p LIMPTS=1000 ITL5=0 RELTOL=0.01 ABSTOL=5e-10 VNTOL=5e-4

.MODEL N NMOS LEVEL=1
+KP=60E-6 VTO=0.7 GAMMA=0.3 LAMBDA=0.05 PHI=0.6
+LD=0.1E-6 TOX=100E-9 CGSO=2.0E-10 CGDO=2.0E-10 CJ=0.2E-3

.MODEL P PMOS LEVEL=1
+KP=20E-6 VTO=-0.7 GAMMA=0.4 LAMBDA=0.05 PHI=0.6
+LD=0.1E-6 TOX=100E-9 CGSO=3.0E-10 CGDO=3.0E-10 CJ=0.2E-3

.MODEL DIFFCAP D CJO=0.2E-3

*** TOP LEVEL CELL: PMOS_lay{lay}
* transistor PMOS: Drain(d), Gate(g), Source(s), Bulk(b)
Mpmos0 d g s b P L=0.36U W=2.16U AS=3.694P AD=3.305P PS=7.74U PD=7.38U

* Voltage sources
Vdd b 0 5
Vs s 0 5
Vd d 0 0
Vg g 0 0

* DC Analysis - PMOS characteristic curves
.dc Vd 0 -5 -0.1 Vg 0 -5 -1

.include "E:\ThietkeIC\PNMOS\PNMOS\PMOS\C5_models.txt"
.END
